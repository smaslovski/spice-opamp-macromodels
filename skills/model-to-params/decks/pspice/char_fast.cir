* <PART> characterization deck FAST (model-to-params skill rev 1.4)
.LIB <vendor model file>
* the part, with the pins in the order inp inn vcc vee out
.subckt DUT inp inn vcc vee out
XV inp inn vcc vee out <VENDOR_SUBCKT>
.ends DUT
* operating condition (datasheet): supplies, input common-mode voltage, load
.param VCC=15 VEE=-15 VCM=0 RL=10k
* nominal values from the datasheet; they set time scales and test levels only
.param GBWN=1Meg SRN=0.5Meg VSTEP=10 VSS=50m OVR=0.2 W=3 ILOAD=1m
* derived (do not edit)
.param TS={4*VSTEP/SRN+5/GBWN} TR={(W+OVR)*1e4/SRN+1e4/GBWN}
.param VSH={min(1,0.2*(VCC-VEE))} VCL={min(1.5,0.9*(VCC-VCM))}
.param VOD={max(0.5,min(5,3*SRN/(6.283*GBWN)))}

Vcc vcc 0 {VCC}
Vee vee 0 {VEE}
Vmid mid 0 {VCM}
* 1: follower at VCM, own supplies, no load: offset, bias currents, supply current
Vcc1 vcc1 0 {VCC}
Vee1 vee1 0 {VEE}
Vp1 mid p1 0
Vn1 o1 n1 0
X1 p1 n1 vcc1 vee1 o1 DUT
* 2: large step VCM-VSTEP/2 -> VCM+VSTEP/2 at TS and back at 3*TS: slew rates in
*    an inverter (G = -1, 10 kohm), where input clamp diodes carry little current,
*    and the follower jump in a follower
Vin2 in2 0 PULSE({VCM-VSTEP/2} {VCM+VSTEP/2} {TS} {TS/1000} {TS/1000} {2*TS} {10*TS})
X2 in2 o2 vcc vee o2 DUT
R2 o2 mid {RL}
Rg2 in2 s2 10k
Rf2 s2 o2i 10k
X2i mid s2 vcc vee o2i DUT
R2i o2i mid {RL}
* 3: follower, small step of VSS
Vin3 in3 0 PULSE({VCM-VSS/2} {VCM+VSS/2} {TS} {TS/1000} {TS/1000} {2*TS} {10*TS})
X3 in3 o3 vcc vee o3 DUT
R3 o3 mid {RL}
* 4, 5, 6: open loop, overdriven by +0.5 V, then -0.5 V from 2.5*TS:
*    swing into RL (4), unloaded (5), and the output current into a short to VCM (6)
Vd4 d4 mid PULSE(0.5 -0.5 {2.5*TS} {TS/100} {TS/100} {10*TS} {20*TS})
X4 d4 mid vcc vee o4 DUT
R4 o4 mid {RL}
X5 d4 mid vcc vee o5 DUT
X6 d4 mid vcc vee o6 DUT
V6 o6 mid 0
* 7, 8: follower stepped from VCM to OVR beyond the top (7) and bottom (8) rail at TS
Vin7 in7 0 PULSE({VCM} {VCC+OVR} {TS} {TS/1000} {TS/1000} {2*TS} {10*TS})
X7 in7 o7 vcc vee o7 DUT
R7 o7 mid {RL}
Vin8 in8 0 PULSE({VCM} {VEE-OVR} {TS} {TS/1000} {TS/1000} {2*TS} {10*TS})
X8 in8 o8 vcc vee o8 DUT
R8 o8 mid {RL}
* 9, 10: VCL between the inputs through 100 ohm (9) and 1 kohm (10): input clamp
Vc9 c9 mid {VCL}
R9 c9 p9 100
X9 p9 mid vcc vee o9 DUT
R10 c9 p10 1k
X10 p10 mid vcc vee o10 DUT
* 11: open loop, no load, overdriven from -VOD to +VOD at TS and back at 3*TS
*     (through 1 kohm, for input clamps): the slew rate where the output crosses
*     VCM, independent of the load. VOD = 3*SRN/(2*pi*GBWN) saturates the input
*     stage (0.5 to 5 V)
Vd11 d11 mid PULSE({-VOD} {VOD} {TS} {TS/1000} {TS/1000} {2*TS} {10*TS})
R11 d11 p11 1k
X11 p11 mid vcc vee o11 DUT
* 12, 13: as 4, into RL/10 (12) and RL/100 (13): saturation voltage vs current
X12 d4 mid vcc vee o12 DUT
R12 o12 mid {RL/10}
X13 d4 mid vcc vee o13 DUT
R13 o13 mid {RL/100}

.OPTIONS NUMDGT=8 NOPAGE
.TRAN {TS/100} {5*TS} 0 {TS/500}
.PRINT TRAN V(o1,mid) I(Vp1) I(Vn1) I(Vcc1) V(o2) V(o2i) V(o3)
.PRINT TRAN V(o4) V(o5) I(V6) V(o7) V(o8)
.PRINT TRAN V(p9,mid) V(c9,p9) V(p10,mid) V(c9,p10)
.PRINT TRAN V(o11) V(o12) V(o13)
.end
