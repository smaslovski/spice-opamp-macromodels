* Test deck for OPAMP_FULL  (ngspice)
* Copyright (c) 2026 Stanislav Maslovski. SPDX-License-Identifier: BSD-2-Clause
.include ../models/opamp_full.lib

Vcc vcc 0 15
Vee vee 0 -15

* --- 1. Open-loop gain/phase (DC loop closed by 1 GH / 1 GF) ---------------------
X1   p1 n1x vcc vee o1 OPAMP_FULL
Vin1 p1 0 0 AC 1
Lfb1 o1 n1x 1e9
Cg1  n1x 0 1e9

* --- 2. Unity-gain follower, +/-5 V step: slew rate and settling ----------------
X2   p2 o2 vcc vee o2 OPAMP_FULL
Vin2 p2 0 PULSE(-5 5 10u 1n 1n 40u 100u)
Rl2  o2 0 2k

* --- 3. Follower, source resistance 100k: output noise, bias current ------------
X3   p3 o3 vcc vee o3 OPAMP_FULL
Rs3  p3s p3 100k
Vin3 p3s 0 0 AC 1

* --- 4. Inverting gain of -10 with 2k load: output swing / clipping --------------
X4   0 n4 vcc vee o4 OPAMP_FULL
Rin4 pin4 n4 1k
Rf4  o4 n4 10k
Rl4  o4 0 2k
Vin4 pin4 0 0

* --- 5. Common-mode gain (both inputs driven, DC servo) --------------------------
X5   pc nc vcc vee o5 OPAMP_FULL
Vcm5 pc 0 0 AC 1
Lfb5 o5 nc 1e9
Cg5  nc pc 1e9

* --- 6. Supply (VCC) rejection ---------------------------------------------------
Vcc6 vcc6 0 15 AC 1
Vee6 vee6 0 -15
X6   0 n6 vcc6 vee6 o6 OPAMP_FULL
Lfb6 o6 n6 1e9
Cg6  n6 0 1e9

* --- 7. Supply (VEE) rejection ---------------------------------------------------
Vcc7 vcc7 0 15
Vee7 vee7 0 -15 AC 1
X7   0 n7 vcc7 vee7 o7 OPAMP_FULL
Lfb7 o7 n7 1e9
Cg7  n7 0 1e9

* --- 8. Follower into 100 ohm: output current limit, supply currents -----------
Vcc8 vcc8 0 15
Vee8 vee8 0 -15
X8   p8 o8 vcc8 vee8 o8 OPAMP_FULL
Rl8  o8 0 100
Vin8 p8 0 0

* --- 9. Follower, no load: input common-mode range ------------------------------
X9   p9 o9 vcc vee o9 OPAMP_FULL
Vin9 p9 0 0

* --- 10. 1/f current noise (FCIN = 2k): 100k at + and 100k in the feedback ------
*         independent pin noise adds: 2*(in*R)^2*(1+FCIN/f); correlated would cancel
X10  p10 n10 vcc vee o10 OPAMP_FULL PARAMS: FCIN=2k
Rs10 s10 p10 100k
Rf10 o10 n10 100k
Vin10 s10 0 0 AC 1

* --- 11. Follower with input-pair tail capacitance KJUMP = 0.25, same step as 2 -
*         expected: output jumps by KJUMP*10 V at the rising edge. While slewing
*         the loop is open, so the output sees RL/(RL+ROUT) = 0.964 of the gain
*         node: expected jump 0.964*2.5 V = 2.41 V; the falling edge is unchanged
X11  p2 o11 vcc vee o11 OPAMP_FULL PARAMS: KJUMP=0.25
Rl11 o11 0 2k

* --- 12. Same with pnp/pmos polarity (KJUMP = -0.25): the jump moves to the falling
*         edge (expected -2.41 V), the rising edge is unchanged
X12  p2 o12 vcc vee o12 OPAMP_FULL PARAMS: KJUMP=-0.25
Rl12 o12 0 2k

* --- 13. Asymmetric slew: SRR = 0.5 V/us, SRF = 1 V/us, same step as 2 ---------
*         expected: rising slew unchanged (ratio 1), falling slew doubled
X13  p2 o13 vcc vee o13 OPAMP_FULL PARAMS: SRR=0.5Meg SRF=1Meg
Rl13 o13 0 2k

* --- 14. Separate PSRR corners: PSRRP = PSRRN = 90 dB, FPSRRP = 10 Hz, FPSRRN = 1 kHz
*         (both used exactly, CMRR derived; both slopes positive). expected at
*         10 kHz: PSRR+ = 90 - 10*log10(1+1e6) = 30.0 dB, PSRR- = 90 -
*         10*log10(1+100) = 69.96 dB (default PSRR+ at 10 kHz: 46.0 dB, see
*         tools/rejection.py)
Vcc14 vcc14 0 15 AC 1
X14   0 n14 vcc14 vee o14 OPAMP_FULL PARAMS: PSRRP=31.62k PSRRN=31.62k FPSRRP=10 FPSRRN=1k
Lfb14 o14 n14 1e9
Cg14  n14 0 1e9
Vee15 vee15 0 -15 AC 1
X15   0 n15 vcc vee15 o15 OPAMP_FULL PARAMS: PSRRP=31.62k PSRRN=31.62k FPSRRP=10 FPSRRN=1k
Lfb15 o15 n15 1e9
Cg15  n15 0 1e9

* --- 15. Phase reversal through an input junction (PRLO = 1, VPRLO = 1) --------
*         input range ends at -13 V (ICMLO = 2), the junction conducts below -14 V;
*         IPR = 0 -> SR*30pF = 15 uA. expected: o16 (-14.5 V in) reversed, at the
*         positive swing limit, input current -15 uA (out of the pin); o17
*         (+14.5 V in) not reversed (no junction at the top): +12.53 V; o18
*         (-14.5 V in through 100k) not reversed: 0.9*100k*15 uA = 1.35 V > 0.5 V
*         overdrive, -12.53 V
Vin16 s16 0 -14.5
Vs16  s16 p16 0
X16   p16 o16 vcc vee o16 OPAMP_FULL PARAMS: PRLO=1 VPRLO=1
Rl16  o16 0 2k
Vin17 p17 0 14.5
X17   p17 o17 vcc vee o17 OPAMP_FULL PARAMS: PRLO=1 VPRLO=1
Rl17  o17 0 2k
Rs18  s16 p18 100k
X18   p18 o18 vcc vee o18 OPAMP_FULL PARAMS: PRLO=1 VPRLO=1
Rl18  o18 0 2k

* --- 16. Rail-to-rail input crossover: VCMT = 1.5, DVOST = 1m, DIBT = -200n --------
*         followers 1 V below and 1 V above the transition (13.5 V); expected
*         offset step = DVOST minus the gain error, I(Vs20) - I(Vs19) = DIBT + RIC current
Vin19 s19 0 12.5
Vs19  s19 p19 0
X19   p19 o19 vcc vee o19 OPAMP_FULL PARAMS: ICMHI=-0.1 ICMLO=-0.1 VHD=0.05 VLD=0.05
+ CMRR=1e12 VCMT=1.5 VKT=0.1 DVOST=1m DIBT=-200n
Vin20 s20 0 14.5
Vs20  s20 p20 0
X20   p20 o20 vcc vee o20 OPAMP_FULL PARAMS: ICMHI=-0.1 ICMLO=-0.1 VHD=0.05 VLD=0.05
+ CMRR=1e12 VCMT=1.5 VKT=0.1 DVOST=1m DIBT=-200n

* --- 17. Follower driven past the top of the input range (ICMHI = 1.5, VK = 0.05) --
*         expected: the output stops near the edge (13.5 V) and stays there as the
*         input rises further (it does not fall back as 2*edge - input)
Vin21 p21 0 14.0
X21   p21 o21 vcc vee o21 OPAMP_FULL PARAMS: ICMHI=1.5 VK=0.05 VHD=0.2
Rl21  o21 0 10k
Vin22 p22 0 14.8
X22   p22 o22 vcc vee o22 OPAMP_FULL PARAMS: ICMHI=1.5 VK=0.05 VHD=0.2
Rl22  o22 0 10k

* --- 19. DC output resistance: ROUT = 33, ROUTDC = 2850, A0 = 8.6k, GBW = 1.78Meg,
*         VXO = 0 (the npn reference A of tests/transistor_level). Open-loop Zout
*         (1 A AC into the output, DC loop closed by 1 GH / 1 GF). expected: 2883 ohm
*         at 0.1 Hz, ROUT + ROUTDC/sqrt(2) ~ 2048 ohm near fd = GBW/A0 = 207 Hz,
*         33 ohm at 1 MHz
X24  0 n24 vcc vee o24 OPAMP_FULL PARAMS: A0=8.6k GBW=1.78Meg ROUT=33 ROUTDC=2850 VXO=0
Lfb24 o24 n24 1e9
Cg24 n24 0 1e9
I24  0 o24 AC 1

* --- 20. Signed rejection values: PSRRP = 31.62k with PSRRN = +31.62k (X25) and
*         -31.62k (X26), common-mode gain as in test 5; CMRR is derived.
*         expected (tools/rejection.py): 84.7 dB (equal signs, the errors add)
*         and 106.0 dB (opposite signs, only 1/A0 is left). X27 = X6 with
*         PSRRP = -31.62k: the vcc response of X27 is opposite in phase to that
*         of X28 (PSRRP = +31.62k): 180 deg
X25  pc n25 vcc vee o25 OPAMP_FULL PARAMS: PSRRP=31.62k PSRRN=31.62k
Lfb25 o25 n25 1e9
Cg25 n25 pc 1e9
X26  pc n26 vcc vee o26 OPAMP_FULL PARAMS: PSRRP=31.62k PSRRN=-31.62k
Lfb26 o26 n26 1e9
Cg26 n26 pc 1e9
X27  0 n27 vcc6 vee6 o27 OPAMP_FULL PARAMS: PSRRP=-31.62k PSRRN=31.62k
Lfb27 o27 n27 1e9
Cg27 n27 0 1e9
X28  0 n28 vcc6 vee6 o28 OPAMP_FULL PARAMS: PSRRP=31.62k PSRRN=31.62k
Lfb28 o28 n28 1e9
Cg28 n28 0 1e9

* --- 21. Saturation resistance: open loop, overdriven, 10 mA load current.
*         ROUT = 50, VHD = VLD = 1, VXO = 0. Expected headroom: RSATH = 100
*         sourcing 1 + 100*10m = 2.0 V (o29 = 13.0 V); RSATL = 10 sinking
*         1 + 10*10m = 1.1 V (o30 = -13.9 V); default (= ROUT) sourcing 1.5 V
*         (o31 = 13.5 V)
Vp29 p29 0 0.5
X29  p29 0 vcc vee o29 OPAMP_FULL PARAMS: ROUT=50 RSATH=100 RSATL=10 VHD=1 VLD=1 VXO=0
I29  o29 vee DC 10m
Vp30 p30 0 -0.5
X30  p30 0 vcc vee o30 OPAMP_FULL PARAMS: ROUT=50 RSATH=100 RSATL=10 VHD=1 VLD=1 VXO=0
I30  vcc o30 DC 10m
X31  p29 0 vcc vee o31 OPAMP_FULL PARAMS: ROUT=50 VHD=1 VLD=1 VXO=0
I31  o31 vee DC 10m

* --- 22. Output inductance: open-loop Zout as in test 19, with ROUT = 33, LOUT = 1u,
*         RLOUT = 40, COUT = 12p, VXO = 0. Theory: |33 + (jwL || 40)| || COUT =
*         34.5 ohm at 1 MHz, 64.9 ohm at 10 MHz, 72.1 ohm at 30 MHz
X32  0 n32 vcc vee o32 OPAMP_FULL PARAMS: ROUT=33 LOUT=1u RLOUT=40 COUT=12p VXO=0
Lfb32 o32 n32 1e9
Cg32 n32 0 1e9
I32  0 o32 AC 1

* --- 18. No ground node: floating follower (input shorted to the supply common,
*         AC and DC on the common). expected: V(o23)-V(c23) = VOS, unchanged when the
*         whole circuit is lifted by 100 V, no AC output (< -200 dB) and no current
*         in Vfl23
Vfl23 c23 0 DC 0 AC 1
Vsp23 vcc23 c23 15
Vsn23 c23 vee23 15
X23   c23 o23 vcc23 vee23 o23 OPAMP_FULL
Rl23  o23 c23 1k

.control
  op
  echo "--- DC operating point ---"
  print v(o1) v(o3) v(p3) v(o4)
  * expected: o1 = VOS, p3 = -(IB+IOS/2)*100k, o3 = p3 + VOS,
  *           o4 = 11*VOS + (IB-IOS/2)*10k
  print -i(Vcc8) i(Vee8)
  * expected (no load current): ICCQ in each rail
  * test 15: phase reversal (expected o16 +12.53 V, i(Vs16) -15 uA; o17 and o18
  *          at the swing limits, +12.53 V and -12.53 V, i.e. not reversed)
  print v(o16) i(Vs16) v(o17) v(o18)
  * test 16: crossover (expected 1 mV - 2 V/A0 = 0.990 mV and -200 nA + 2 V/400 Meg = -195 nA)
  let dvos16 = (v(o20)-v(s20))-(v(o19)-v(s19))
  let dib16 = i(Vs20)-i(Vs19)
  print dvos16 dib16
  * test 17: follower past the input range (expected: equal outputs near 13.5 V)
  print v(o21) v(o22)
  * test 18: floating follower (expected VOS = 1 mV and 0 A)
  let float18 = v(o23)-v(c23)
  print float18 i(Vfl23)
  * test 21: saturation resistance (expected 13.0, -13.9, 13.5 V)
  print v(o29) v(o30) v(o31)

  ac dec 20 0.1 100Meg
  let ad    = vdb(o1)
  let phd   = 180/pi*cph(o1)
  let cmrr  = vdb(o1)-vdb(o5)
  let psrrp = vdb(o1)-vdb(o6)
  let psrrn = vdb(o1)-vdb(o7)
  meas ac a0_db   find ad at=0.1
  meas ac fu      when ad=0
  meas ac ph_fu   find phd when ad=0
  let pm = 180+ph_fu
  print pm
  * expected (defaults, tools/rejection.py): CMRR 90.0 dB flat, PSRR+ 89.3 dB,
  * PSRR- 112.0 dB at DC
  meas ac cmrr_dc find cmrr at=0.1
  meas ac cmrr_1k find cmrr at=1k
  meas ac psrrp_dc find psrrp at=0.1
  meas ac psrrn_dc find psrrn at=0.1
  * test 14: separate PSRR corners (theory: 30.0, 69.96 and 50.0 dB at 10 kHz)
  let psrrp14 = vdb(o1)-vdb(o14)
  let psrrn14 = vdb(o1)-vdb(o15)
  meas ac psrrp14_10k find psrrp14 at=10k
  meas ac psrrn14_10k find psrrn14 at=10k
  meas ac psrrp_10k find psrrp at=10k
  * test 19: DC output resistance (expected 2883, ~2048 at 207 Hz, 33 ohm)
  meas ac zo19_dc find vm(o24) at=0.1
  meas ac zo19_fd find vm(o24) at=207
  meas ac zo19_1m find vm(o24) at=1Meg
  * test 22: output inductance (expected 34.5, 64.9 and 72.1 ohm)
  meas ac zo22_1m find vm(o32) at=1Meg
  meas ac zo22_10m find vm(o32) at=10Meg
  meas ac zo22_30m find vm(o32) at=30Meg
  * test 20: signed values (expected 84.7 and 106.0 dB, 180 deg)
  let cmrr20a = vdb(o1)-vdb(o25)
  let cmrr20b = vdb(o1)-vdb(o26)
  let ph20 = abs(180/pi*cph(v(o27)/v(o28)))
  meas ac cmrr20a_dc find cmrr20a at=0.1
  meas ac cmrr20b_dc find cmrr20b at=0.1
  meas ac ph20_dc find ph20 at=0.1
  * test 18: floating follower, |V(o23)-V(c23)| (expected < -200 dB)
  let fl18 = db(abs(v(o23)-v(c23))+1e-30)
  meas ac float18_max max fl18
  * Open-loop gain and phase
  plot ad title 'Open-loop gain (dB)' xlog
  plot phd title 'Open-loop phase (deg)' xlog
  * CMRR(f) = Ad/Acm and PSRR(f) = Ad/Avs
  plot cmrr title 'CMRR (dB)' xlog
  plot psrrp psrrn title 'PSRR+ and PSRR- (dB)' xlog

  tran 0.05u 100u
  * slew rate from the 10%..90% transition (8 V); the peak dV/dt is dominated
  * by the 1 ns input edge coupling through CID and is not a slew rate
  meas tran t_rise trig v(o2) val=-4 rise=1 targ v(o2) val=4 rise=1
  meas tran t_fall trig v(o2) val=4 fall=1 targ v(o2) val=-4 fall=1
  let sr_rise = 8/t_rise/1e6
  let sr_fall = 8/t_fall/1e6
  print sr_rise sr_fall
  * 1 mV settling time after the rising input edge at 10 us
  meas tran v_final find v(o2) at=48u
  let vhi = v_final+1m
  let vlo = v_final-1m
  meas tran v_peak max v(o2) from=10u to=48u
  * last time |v(o2)-v_final| leaves the 1 mV band (from above or below)
  meas tran t_hi when v(o2)=vhi cross=last from=10u to=48u
  meas tran t_lo when v(o2)=vlo cross=last from=10u to=48u
  let t_settle = 0.5*(t_hi+t_lo+abs(t_hi-t_lo)) - 10u
  print t_settle
  * test 11: tail-capacitance jump (theory: jump 2.41 V, fall-time ratio 1)
  meas tran v11 find v(o11) at=10.3u
  meas tran v2r find v(o2) at=10.3u
  let jump11 = v11 - v2r
  meas tran t_fall11 trig v(o11) val=4 fall=1 targ v(o11) val=-4 fall=1
  let fall_ratio11 = t_fall11/t_fall
  print jump11 fall_ratio11
  * test 12: KJUMP = -0.25 (theory: jump -2.41 V on the falling edge, rise-time ratio 1)
  meas tran v12 find v(o12) at=50.3u
  meas tran v2f find v(o2) at=50.3u
  let jump12 = v12 - v2f
  meas tran t_rise12 trig v(o12) val=-4 rise=1 targ v(o12) val=4 rise=1
  let rise_ratio12 = t_rise12/t_rise
  print jump12 rise_ratio12
  * test 13: asymmetric slew (theory: rise ratio 1, fall slew ratio 2)
  meas tran t_rise13 trig v(o13) val=-4 rise=1 targ v(o13) val=4 rise=1
  meas tran t_fall13 trig v(o13) val=4 fall=1 targ v(o13) val=-4 fall=1
  let rise_ratio13 = t_rise13/t_rise
  let fall_sr_ratio13 = t_fall/t_fall13
  print rise_ratio13 fall_sr_ratio13
  plot v(p2) v(o2) title 'Follower step (slew rate)'

  dc Vin4 -3 3 0.05
  meas dc vo_max max v(o4)
  meas dc vo_min min v(o4)
  plot v(o4) title 'Inverting gain -10: output swing'

  dc Vin8 -5 5 0.05
  let iload = v(o8)/100
  meas dc i_src max iload
  meas dc i_snk min iload
  plot v(o8) title 'Follower into 100 ohm: current limit'
  let icc8 = -i(Vcc8)
  let iee8 = i(Vee8)
  plot icc8 iee8 title 'Supply currents vs load current'

  * test 18: the whole floating circuit lifted by 100 V (expected 0 V and 0 A)
  dc Vfl23 0 100 100
  let lift18 = (v(o23)[1]-v(c23)[1])-(v(o23)[0]-v(c23)[0])
  let ilift18 = i(Vfl23)[1]
  print lift18 ilift18

  dc Vin9 -15 15 0.05
  plot v(o9) v(p9) title 'Follower: input common-mode range'

  noise v(o3) Vin3 dec 20 1 1Meg
  * the spectral-density plot is the one before the integrated-noise plot
  setplot previous
  * expected for the default parameters: en^2*(1+FCEN/f) + (in*Rs)^2 + 4kT*Rs
  let en_exp = sqrt((20n)^2*(1+200/frequency) + (0.5p*100k)^2 + 4*1.380649e-23*300.15*100k)
  let ratio = onoise_spectrum/en_exp
  * points 20, 60, 80 of the dec-20 sweep are 10 Hz, 1 kHz, 10 kHz
  print frequency[20] onoise_spectrum[20] en_exp[20] ratio[20]
  print frequency[60] onoise_spectrum[60] en_exp[60] ratio[60]
  print frequency[80] onoise_spectrum[80] en_exp[80] ratio[80]
  plot onoise_spectrum en_exp loglog title 'Output noise density (V/rtHz), model vs expected'

  noise v(o10) Vin10 dec 20 0.1 10k
  setplot previous
  * expected: en^2*(1+FCEN/f) + 2*(in*R)^2*(1+FCIN/f) + 2*4kT*R
  let en_exp10 = sqrt((20n)^2*(1+200/frequency) + 2*(0.5p*100k)^2*(1+2k/frequency) + 2*4*1.380649e-23*300.15*100k)
  let ratio10 = onoise_spectrum/en_exp10
  let r10min = vecmin(ratio10)
  let r10max = vecmax(ratio10)
  * points 0, 40, 100 of the dec-20 sweep are 0.1 Hz, 10 Hz, 10 kHz
  print frequency[0] onoise_spectrum[0] en_exp10[0] ratio10[0]
  print frequency[40] onoise_spectrum[40] en_exp10[40] ratio10[40]
  print frequency[100] onoise_spectrum[100] en_exp10[100] ratio10[100]
  print r10min r10max
.endc
.end
